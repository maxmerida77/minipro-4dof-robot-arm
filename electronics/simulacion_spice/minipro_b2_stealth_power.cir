* ============================================================================
* Mini-Pro 4-DOF (B2 Stealth v4) - Netlist SPICE de Etapa de Potencia y OCP 3A
* ============================================================================
* Compatible con ngspice (integrado en KiCad 9.0) - 100% sincronizado con
* `simular_potencia_ngspice.py` y `minipro_b2_stealth.kicad_sch`:
*   Cargador UGREEN 50W (USB-C PD 5V / OCP 3.0 A) -> AR5515 (5V) -> KCD11-2P ->
*     -> Bus +5V_SERVO + Capacitor 1000uF 16V (AR1127) -> PCA9685 V+ (4xMG90S+SG90)
*     -> Diodo Schottky 1N5819 (AR0195) -> XIAO ESP32-S3 5V_IN (Wi-Fi activo 220mA)
* ============================================================================

* --- 1. Alimentacion USB-C PD con Limite Real OCP 3.0 A (UGREEN 50W en 5V) ---
B_PD       n_pd_ocp   0        V = 5.05 - 3.5*max(0, i(V_SENSE) - 3.0)
V_SENSE    n_pd_ocp   n_pd_int DC 0
R_SRC      n_pd_int   n_pd_l   0.24
L_SRC      n_pd_l     n_5v_srv 4.5u

* --- 2. Capacitor Electrolitico 1000uF 16V (AR1127) directo en bornera PCA9685 ---
R_ESR      n_5v_srv   n_c1     0.08
C1         n_c1       0        1000u IC=5.0

* --- 3. Carga Dinamica de los 5 Servos (4x MG90S + 1x SG90, rampas 1100 ms v4) ---
*   10..20ms : arranque suave brazo sin carga (1.75 A)
*   35ms     : pico rapido de conmutacion H-bridge (2.85 A durante 350 us -> absorbido por C1)
*   55..65ms : esfuerzo sostenido J2 extendido + cierre pinza (2.05 A)
I_SERVOS   n_5v_srv   0        PWL(0 0.15 9.95m 0.15 10.0m 1.75 20.0m 1.75 21.0m 0.65 34.98m 0.65 35.0m 2.85 35.35m 2.85 35.40m 0.65 54.95m 0.65 55.0m 2.05 65.0m 2.05 66.0m 0.20 85.0m 0.20)

* --- 4. Diodo Schottky Antirretorno 1N5819 (AR0195) hacia XIAO ESP32-S3 5V_IN ---
D1         n_5v_srv   n_5v_xiao D1N5819
.model D1N5819 D(IS=2.6e-5 N=1.08 RS=0.055 BV=40 IBV=1m CJO=110p VJ=0.35 M=0.38)

* --- 5. Carga XIAO ESP32-S3 (Wi-Fi UDP + Web UI activos: ~220 mA + cap 22uF onboard) ---
C_XIAO     n_5v_xiao  0        22u IC=4.68
I_XIAO     n_5v_xiao  0        DC 0.22

.tran 25u 85m UIC
.end
